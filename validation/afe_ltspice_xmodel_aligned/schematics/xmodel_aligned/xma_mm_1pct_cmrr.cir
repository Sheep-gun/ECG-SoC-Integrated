* C:\Users\YangGeon\Desktop\ECG_AFE_LTspice\ltspice_validation\schematics\xmodel_aligned\FULL_AFE_ADC_SH_xmodel_aligned.asc
* Generated by LTspice 26.0.1 for Windows.
X§U1 HPF_P N001 VPLUS VMINUS U1_OUT XOPAMP_XMODEL PARAMS: AOL_DB={AOL_DB} CMRR_DB={CMRR_DB} GBW_HZ={GBW_HZ} VOS={+VOS} ;§pnba In+)In-)V+)V-)OUT
V1 VPLUS 0 1.65
V2 VMINUS 0 -1.65
V5 INN_RAW 0 AC 1
C1 HPF_P INP_RAW {CHPF}
R1 HPF_P 0 {RHPF}
C2 HPF_N INN_RAW {CHPF}
R2 HPF_N 0 {RHPF}
X§U2 HPF_N N005 VPLUS VMINUS U2_OUT XOPAMP_XMODEL PARAMS: AOL_DB={AOL_DB} CMRR_DB={CMRR_DB} GBW_HZ={GBW_HZ} VOS={-VOS} ;§pnba In+)In-)V+)V-)OUT
R3 N001 U1_OUT {100k*P}
R4 N005 U2_OUT {100k*N}
X§U3 N002 N004 VPLUS VMINUS IA_OUT XOPAMP_XMODEL PARAMS: AOL_DB={AOL_DB} CMRR_DB={CMRR_DB} GBW_HZ={GBW_HZ} VOS={0} ;§pnba In+)In-)V+)V-)OUT
R5 N002 U1_OUT {10k*P}
R6 N004 U2_OUT {10k*N}
R7 N002 0 {10k*N}
R8 IA_OUT N004 {10k*P}
R9 N001 N005 1k
V3 INP_RAW 0 AC 1
R10 INP_RAW 0 1G
R11 INN_RAW 0 1G
R12 N003 IA_OUT {RNOTCH*P}
R13 NOTCH_SENSE N003 {RNOTCH*N}
C3 N003 VK {200n*P}
C4 N006 IA_OUT {CNOTCH*N}
C5 NOTCH_SENSE N006 {CNOTCH*P}
R14 VK N006 {13.263k*N}
X§U4 NOTCH_SENSE LPF_IN VPLUS VMINUS LPF_IN XOPAMP_XMODEL PARAMS: AOL_DB={AOL_DB} CMRR_DB={CMRR_DB} GBW_HZ={GBW_HZ} VOS={0} ;§pnba In+)In-)V+)V-)OUT
R15 K_DIV LPF_IN {RK1}
R16 K_DIV 0 {RK2}
X§U5 K_DIV VK VPLUS VMINUS VK XOPAMP_XMODEL PARAMS: AOL_DB={AOL_DB} CMRR_DB={CMRR_DB} GBW_HZ={GBW_HZ} VOS={0} ;§pnba In+)In-)V+)V-)OUT
R17 LPF_NODE LPF_IN {RLPF}
C6 LPF_NODE 0 {CLPF}
X§U6 LPF_NODE AFE_OUT VPLUS VMINUS AFE_OUT XOPAMP_XMODEL PARAMS: AOL_DB={AOL_DB} CMRR_DB={CMRR_DB} GBW_HZ={GBW_HZ} VOS={0} ;§pnba In+)In-)V+)V-)OUT
B1 ADC_CLIP 0 V=limit(V(ADC_HOLD),-1.65,1.65)
B2 ADC_CODE 0 V=limit(floor((V(ADC_CLIP)+1.65)/3.3*4095),0,4095)
B3 ADC_SIGNED 0 V=V(ADC_CODE)-2048
V4 CLK 0 PULSE(0 5 900u 1u 1u 98u 1m)
S1 AFE_OUT ADC_HOLD CLK 0 SW_ADC
C7 ADC_HOLD 0 10n
R18 ADC_HOLD 0 1G
.param RHPF=10Meg
.param CHPF=33n
.param RFB=100k
.param RG=1k
.param RDIFF=10k
.param RNOTCH=26.526k
.param CNOTCH=100n
.param RK1=5k
.param RK2=95k
.param RLPF=1k
.param CLPF=1.06u
.param VADC=1.65
.options plotwinsize=0
* XMODEL-ALIGNED: +/-1.65V, dedicated 100dB/110dB/1ohm op-amp, ECG+=patient, ECG-=0, aperture=1ms.
.model SW_ADC SW(Ron=1 Roff=1G Vt=2.5 Vh=0.1)
.include XOpAmp_XMODEL.lib
.param AOL_DB=100 CMRR_DB=110 GBW_HZ=1e9 VOS=0
.param MM=0.01 P={1+MM} N={1-MM}
.ac list 10
.save V(INP_RAW) V(INN_RAW) V(IA_OUT)
.end
